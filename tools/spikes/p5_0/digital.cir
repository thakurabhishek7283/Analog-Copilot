* p50 digital: 4-bit ripple counter (T flip-flops), half adder, 4-bit R-2R DAC of the count
Vclk clk 0 PULSE(0 5 0 1n 1n 0.5u 1u)
Aadc [clk] [dclk] adc1
Ahigh one pull1
At0 one dclk null null q0 nq0 tff1
At1 one nq0 null null q1 nq1 tff1
At2 one nq1 null null q2 nq2 tff1
At3 one nq2 null null q3 nq3 tff1
Axor [q0 q1] sum xor1
Aand [q0 q1] carry and1
Adac [q0 q1 q2 q3 sum carry] [a0 a1 a2 a3 asum acarry] dac1
* R-2R ladder: vout = 5 * count / 16
R0t a0 n0 20k
R1t a1 n1 20k
R2t a2 n2 20k
R3t a3 n3 20k
Rterm n0 0 20k
R01 n0 n1 10k
R12 n1 n2 10k
R23 n2 n3 10k
Rl1 asum 0 100k
Rl2 acarry 0 100k
.model adc1 adc_bridge(in_low=1.0 in_high=2.0)
.model pull1 d_pullup(load=1p)
.model tff1 d_tff(clk_delay=10n set_delay=10n reset_delay=10n ic=0 rise_delay=10n fall_delay=10n)
.model xor1 d_xor(rise_delay=10n fall_delay=10n)
.model and1 d_and(rise_delay=10n fall_delay=10n)
.model dac1 dac_bridge(out_low=0 out_high=5 out_undef=2.5 t_rise=5n t_fall=5n)
.tran 10n 40u
.meas tran q3_period trig v(a3) val=2.5 rise=1 targ v(a3) val=2.5 rise=2
.meas tran q0_period trig v(a0) val=2.5 rise=2 targ v(a0) val=2.5 rise=3
.meas tran dac_max max v(n3)
.meas tran dac_at_10u5 find v(n3) at=10.75u
.meas tran sum_at_1u5 find v(asum) at=1.75u
.meas tran carry_at_3u5 find v(acarry) at=3.75u
.end
